# Ansys Electronics Desktop project, version 2018.2
materials:
  vacuum: permittivity=1
  copper: permeability=0.999991 conductivity=58000000
  FR4_epoxy: permittivity=4.4 dielectric_loss_tangent=0.02
  Teflon (tm): permittivity=2.1 dielectric_loss_tangent=0.001
  air: permittivity=1.0006 permeability=1.0000004

design HFSSDesign2 (HFSS, DrivenModal, model units mm)
variables:
  substrate_w = 170mm
  meta_des = 18.3mm
  x_length = 77mm
  y_length = 77mm
  meta_substrate = 175mm
  under_height = 0.42mm
  change = 4.8mm
  substrate_thick = 1mm
  meta_thick = 1.6mm
  under_width = 4mm
  under_y = 136mm
  new_underdes = 81mm
  new_underdes_right = 81mm
  new_underdes2 = 81mm
  change_right = 0.39mm
  change_left = 0.42mm
geometry:
  Archimedian1 = component(NumberOfPoints=200, NumberOfArms=2, InnerRadius=3mm, NumberOfTurns=3, Offset=155deg, ConeHeight=0mm, ExpansionCoefficient=6.6, SpiralCoefficient=1.22, Port_Extension=0.1)
  Port1, AntennaArm1, AntennaArm2 [copper] = part_of(Archimedian1)
  RadiatingSurface [vacuum] = region(absolute_offset=109.89011mm on all sides)
  Substrate [FR4_epoxy] = box(corner=(-substrate_w/2, -substrate_w/2, 0mm), size=(substrate_w, substrate_w, -substrate_thick))
  Box7 [FR4_epoxy] = box(corner=(75mm, -new_underdes, -substrate_thick), size=(-150mm, under_width, -change_left))
  Box8 [FR4_epoxy] = box(corner=(75mm, new_underdes_right, -substrate_thick), size=(-150mm, -under_width, -change_right))
  Box9 [FR4_epoxy] = box(corner=(new_underdes2, -70.5mm, -substrate_thick), size=(-30mm-change, under_y, -under_height))
  Box10 [FR4_epoxy] = box(corner=(-new_underdes2, 70mm+under_y-140.5mm, -substrate_thick), size=(30mm+change, -under_y, -under_height))
  meta [FR4_epoxy] = box(corner=(-meta_substrate/2, -meta_substrate/2, meta_des), size=(meta_substrate, meta_substrate, -meta_thick))
  Rectangle32 = rectangle(corner=(new_underdes2, -70.5mm, -substrate_thick-under_height), x_size=-30mm-change, y_size=under_y)
  Rectangle33 = rectangle(corner=(-new_underdes2, -70.5mm, -substrate_thick-under_height), x_size=30mm+change, y_size=under_y)
  Rectangle34 = rectangle(corner=(75mm, -new_underdes, -substrate_thick-change_left), x_size=-150mm, y_size=under_width)
  Rectangle36 = rectangle(corner=(-10mm, -10mm, meta_des), x_size=-x_length, y_size=-y_length)
  Rectangle37 = rectangle(corner=(-10mm, 10mm, meta_des), x_size=-x_length, y_size=y_length)
  Rectangle38 = rectangle(corner=(10mm, -10mm, meta_des), x_size=x_length, y_size=-y_length)
  Rectangle39 = rectangle(corner=(10mm, 10mm, meta_des), x_size=x_length, y_size=y_length)
  Rectangle40 = rectangle(corner=(75mm, new_underdes_right, -substrate_thick-change_right), x_size=-150mm, y_size=-under_width)
  AntennaArm3 = part_of(Archimedian1)
  AntennaArm3.delete()
boundaries and excitations:
  FiniteCond1: Finite Conductivity Objects=[AntennaArm1, AntennaArm2] Conductivity=58000000 Permeability=1 IsInternal
  Open1: Radiation Objects=RadiatingSurface
  FiniteCond10: Finite Conductivity Objects=[Rectangle33, Rectangle32] Conductivity=58000000 Permeability=1 IsInternal
  FiniteCond11: Finite Conductivity Objects=[Rectangle40, Rectangle34] Conductivity=58000000 Permeability=1 IsInternal
  FiniteCond12: Finite Conductivity Objects=[Rectangle36, Rectangle38, Rectangle37, Rectangle39] Conductivity=58000000 Permeability=1 IsInternal
  1: Lumped Port Objects=Port1 Modes{Mode1{IntLine{middle of Port1.edge(#12) -> middle of Port1.edge(#14)} CharImp=Zpi RenormImp=50ohm}} Impedance=50ohm
setups:
  Setup1: HfssDriven Frequency=910MHz MaxDeltaS=0.02 MaximumPasses=10 MinimumPasses=1 MinimumConvergedPasses=1 PercentRefinement=30 BasisOrder=1 PortAccuracy=2
    sweep Sweep: 860MHz to 1000MHz, 650 points; Type=Fast SaveFields
source amplitudes:
  1:1: 1W 0deg
radiation setups:
  3D: Infinite Sphere Theta=0deg..180deg step 2deg Phi=-180deg..180deg step 2deg
  Elevation: Infinite Sphere Theta=-180deg..180deg step 1deg Phi=0deg..90deg step 90deg
  Azimuth: Infinite Sphere Theta=90deg..90deg step 0deg Phi=-180deg..180deg step 1deg
reports:
  S Parameter Plot 1: dB(S(1,1)) vs Freq on Setup1 : Sweep; markers m1 at 910.00006MHz
  Gain Plot 3: dB(GainTotal) vs Phi, Theta on Setup1 : Sweep, 3D [Freq=0.909875GHz]
  Gain Plot 10: dB(GainTotal) vs Freq on Setup1 : Sweep, 3D [Freq=0.86GHz,0.864912GHz,0.870175GHz,0.875088GHz,0.88GHz,0.884912GHz,0.890175GHz,0.895088GHz,0.9GHz,0.904912GHz,0.907368GHz,0.910175GHz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 Phi=0deg Theta=0deg]; markers m1 at 0.90999999GHz
  Axial Ratio Plot 1: dB(AxialRatioValue) vs Freq on Setup1 : Sweep, 3D [Freq=0.86GHz,0.864912GHz,0.870175GHz,0.875088GHz,0.88GHz,0.884912GHz,0.890175GHz,0.895088GHz,0.9GHz,0.904912GHz,0.907368GHz,0.910175GHz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 Phi=0deg Theta=0deg]; markers m1 at 0.86GHz, m2 at 0.90999996GHz, m3 at 0.96GHz
  Axial Ratio Plot 2: dB(AxialRatioValue) vs Freq on Setup1 : Sweep, 3D [Freq=0.86GHz,0.864912GHz,0.870175GHz,0.875088GHz,0.88GHz,0.884912GHz,0.890175GHz,0.895088GHz,0.9GHz,0.904912GHz,0.907368GHz,0.910175GHz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 Phi=0deg Theta=0deg substrate_thick=1mm,1.4mm]
